; ============================================================
; Auto-generated Cadence Allegro Constraint Script
; Generated by BRD-AI System
; 2026-08-28 15:46:28
; Board: 860-000776_PSE_Board
; Capability: extreme
; ============================================================
;
; 使用方法:
;   1. 打开 Allegro PCB Editor
;   2. 在Command窗口输入: skill load "auto_constraint.il"
;   3. 或: File -> Script -> Replay -> 选择此文件
;
; ============================================================

(defun BRD_AI_CreateAllConstraints ()
  (let (result)
    (printf "\n========================================\n")
    (printf "BRD-AI: 开始创建 Constraint...\n")
    (printf "========================================\n\n")

    ; ---- 进入 Constraint Manager ----
    (axlCNSEnter)

    ; ---- Net Class: POWER (8 nets) ----
    (printf "Creating Net Class: POWER\n")
    (axlCNSAddNetClass "POWER"
      '(

        "24V"

        "24V_BEAD"

        "24V_CMC"

        "24V_MB"

        "3V3_MB"

        "3V3_PSE"

        "VBUS"

        "VBUS_DET"

      ))
    (printf "  -> POWER: 8 nets added\n")

    ; ---- Net Class: GND (7 nets) ----
    (printf "Creating Net Class: GND\n")
    (axlCNSAddNetClass "GND"
      '(

        "GND"

        "GND_BEAD"

        "GND_CMC"

        "GND_MB"

        "AGND"

        "GND1"

        "GND2"

      ))
    (printf "  -> GND: 7 nets added\n")

    ; ---- Net Class: GATE_DRIVE (8 nets) ----
    (printf "Creating Net Class: GATE_DRIVE\n")
    (axlCNSAddNetClass "GATE_DRIVE"
      '(

        "CH1_GATE"

        "CH2_GATE"

        "CH3_GATE"

        "CH4_GATE"

        "CH5_GATE"

        "CH6_GATE"

        "CH7_GATE"

        "CH8_GATE"

      ))
    (printf "  -> GATE_DRIVE: 8 nets added\n")

    ; ---- Net Class: SENSE (8 nets) ----
    (printf "Creating Net Class: SENSE\n")
    (axlCNSAddNetClass "SENSE"
      '(

        "CH1_SEN"

        "CH2_SEN"

        "CH3_SEN"

        "CH4_SEN"

        "CH5_SEN"

        "CH6_SEN"

        "CH7_SEN"

        "CH8_SEN"

      ))
    (printf "  -> SENSE: 8 nets added\n")

    ; ---- Net Class: CLOCK (2 nets) ----
    (printf "Creating Net Class: CLOCK\n")
    (axlCNSAddNetClass "CLOCK"
      '(

        "CLK_25MHZ"

        "CLK_25MHZ_N"

      ))
    (printf "  -> CLOCK: 2 nets added\n")

    ; ---- Net Class: RESET (3 nets) ----
    (printf "Creating Net Class: RESET\n")
    (axlCNSAddNetClass "RESET"
      '(

        "RESET_N"

        "POR_B"

        "SPI_CS_N"

      ))
    (printf "  -> RESET: 3 nets added\n")

    ; ---- Net Class: SPI (3 nets) ----
    (printf "Creating Net Class: SPI\n")
    (axlCNSAddNetClass "SPI"
      '(

        "SPI_MISO"

        "SPI_MOSI"

        "SPI_SCLK"

      ))
    (printf "  -> SPI: 3 nets added\n")

    ; ---- Net Class: I2C (2 nets) ----
    (printf "Creating Net Class: I2C\n")
    (axlCNSAddNetClass "I2C"
      '(

        "I2C_SDA"

        "I2C_SCL"

      ))
    (printf "  -> I2C: 2 nets added\n")

    ; ---- Net Class: ETHERNET (22 nets) ----
    (printf "Creating Net Class: ETHERNET\n")
    (axlCNSAddNetClass "ETHERNET"
      '(

        "ETH_MDI0_P"

        "ETH_MDI0_N"

        "ETH_MDI1_P"

        "ETH_MDI1_N"

        "ETH_MDI2_P"

        "ETH_MDI2_N"

        "ETH_MDI3_P"

        "ETH_MDI3_N"

        "ETH_RGMII_TX0"

        "ETH_RGMII_TX1"

        "ETH_RGMII_TX2"

        "ETH_RGMII_TX3"

        "ETH_RGMII_RX0"

        "ETH_RGMII_RX1"

        "ETH_RGMII_RX2"

        "ETH_RGMII_RX3"

        "ETH_RGMII_TXC"

        "ETH_RGMII_RXC"

        "ETH_RGMII_TX_CTL"

        "ETH_RGMII_RX_CTL"

        "UART_TX"

        "UART_RX"

      ))
    (printf "  -> ETHERNET: 22 nets added\n")

    ; ---- Net Class: LED (2 nets) ----
    (printf "Creating Net Class: LED\n")
    (axlCNSAddNetClass "LED"
      '(

        "LED_STATUS"

        "LED_FAULT"

      ))
    (printf "  -> LED: 2 nets added\n")

    ; ---- Net Class: JTAG (5 nets) ----
    (printf "Creating Net Class: JTAG\n")
    (axlCNSAddNetClass "JTAG"
      '(

        "JTAG_TMS"

        "JTAG_TCK"

        "JTAG_TDI"

        "JTAG_TDO"

        "JTAG_TRST"

      ))
    (printf "  -> JTAG: 5 nets added\n")

    ; ---- Net Class: DEFAULT (10 nets) ----
    (printf "Creating Net Class: DEFAULT\n")
    (axlCNSAddNetClass "DEFAULT"
      '(

        "SW1"

        "SW2"

        "SW3"

        "SW4"

        "TP1"

        "TP2"

        "TP3"

        "TP4"

        "TP5"

        "TP6"

      ))
    (printf "  -> DEFAULT: 10 nets added\n")

    ; ---- Net Class: CAN (2 nets) ----
    (printf "Creating Net Class: CAN\n")
    (axlCNSAddNetClass "CAN"
      '(

        "CANH"

        "CANL"

      ))
    (printf "  -> CAN: 2 nets added\n")

    (printf "\nNet Classes created: 13\n\n")

    ; ---- Physical Constraint: PHYS_POWER ----
    (printf "Setting Physical: PHYS_POWER\n")
    (axlCNSAddPhysicalConstraint "PHYS_POWER"
      '("width" "neck_width" "max_width")
      '(0.3 0.3 2.0)
    )
    (axlCNSSetPreferredWidth "PHYS_POWER" 0.5)
    (axlCNSSetNetClassConstraint "PHYS_POWER" "POWER")

    ; ---- Physical Constraint: PHYS_GND ----
    (printf "Setting Physical: PHYS_GND\n")
    (axlCNSAddPhysicalConstraint "PHYS_GND"
      '("width" "neck_width" "max_width")
      '(0.3 0.3 2.0)
    )
    (axlCNSSetPreferredWidth "PHYS_GND" 0.5)
    (axlCNSSetNetClassConstraint "PHYS_GND" "GND")

    ; ---- Physical Constraint: PHYS_GATE_DRIVE ----
    (printf "Setting Physical: PHYS_GATE_DRIVE\n")
    (axlCNSAddPhysicalConstraint "PHYS_GATE_DRIVE"
      '("width" "neck_width" "max_width")
      '(0.3 0.3 1.0)
    )
    (axlCNSSetPreferredWidth "PHYS_GATE_DRIVE" 0.5)
    (axlCNSSetNetClassConstraint "PHYS_GATE_DRIVE" "GATE_DRIVE")

    ; ---- Physical Constraint: PHYS_SENSE ----
    (printf "Setting Physical: PHYS_SENSE\n")
    (axlCNSAddPhysicalConstraint "PHYS_SENSE"
      '("width" "neck_width" "max_width")
      '(0.1 0.1 0.2)
    )
    (axlCNSSetPreferredWidth "PHYS_SENSE" 0.15)
    (axlCNSSetNetClassConstraint "PHYS_SENSE" "SENSE")

    ; ---- Physical Constraint: PHYS_CLOCK ----
    (printf "Setting Physical: PHYS_CLOCK\n")
    (axlCNSAddPhysicalConstraint "PHYS_CLOCK"
      '("width" "neck_width" "max_width")
      '(0.1 0.1 0.2)
    )
    (axlCNSSetPreferredWidth "PHYS_CLOCK" 0.15)
    (axlCNSSetNetClassConstraint "PHYS_CLOCK" "CLOCK")

    ; ---- Physical Constraint: PHYS_RESET ----
    (printf "Setting Physical: PHYS_RESET\n")
    (axlCNSAddPhysicalConstraint "PHYS_RESET"
      '("width" "neck_width" "max_width")
      '(0.1 0.1 0.2)
    )
    (axlCNSSetPreferredWidth "PHYS_RESET" 0.15)
    (axlCNSSetNetClassConstraint "PHYS_RESET" "RESET")

    ; ---- Physical Constraint: PHYS_SPI ----
    (printf "Setting Physical: PHYS_SPI\n")
    (axlCNSAddPhysicalConstraint "PHYS_SPI"
      '("width" "neck_width" "max_width")
      '(0.1 0.1 0.2)
    )
    (axlCNSSetPreferredWidth "PHYS_SPI" 0.15)
    (axlCNSSetNetClassConstraint "PHYS_SPI" "SPI")

    ; ---- Physical Constraint: PHYS_I2C ----
    (printf "Setting Physical: PHYS_I2C\n")
    (axlCNSAddPhysicalConstraint "PHYS_I2C"
      '("width" "neck_width" "max_width")
      '(0.1 0.1 0.2)
    )
    (axlCNSSetPreferredWidth "PHYS_I2C" 0.15)
    (axlCNSSetNetClassConstraint "PHYS_I2C" "I2C")

    ; ---- Physical Constraint: PHYS_ETHERNET ----
    (printf "Setting Physical: PHYS_ETHERNET\n")
    (axlCNSAddPhysicalConstraint "PHYS_ETHERNET"
      '("width" "neck_width" "max_width")
      '(0.09 0.09 0.12)
    )
    (axlCNSSetPreferredWidth "PHYS_ETHERNET" 0.1)
    (axlCNSSetNetClassConstraint "PHYS_ETHERNET" "ETHERNET")

    ; ---- Physical Constraint: PHYS_LED ----
    (printf "Setting Physical: PHYS_LED\n")
    (axlCNSAddPhysicalConstraint "PHYS_LED"
      '("width" "neck_width" "max_width")
      '(0.1 0.1 0.2)
    )
    (axlCNSSetPreferredWidth "PHYS_LED" 0.15)
    (axlCNSSetNetClassConstraint "PHYS_LED" "LED")

    ; ---- Physical Constraint: PHYS_JTAG ----
    (printf "Setting Physical: PHYS_JTAG\n")
    (axlCNSAddPhysicalConstraint "PHYS_JTAG"
      '("width" "neck_width" "max_width")
      '(0.1 0.1 0.2)
    )
    (axlCNSSetPreferredWidth "PHYS_JTAG" 0.15)
    (axlCNSSetNetClassConstraint "PHYS_JTAG" "JTAG")

    ; ---- Physical Constraint: PHYS_DEFAULT ----
    (printf "Setting Physical: PHYS_DEFAULT\n")
    (axlCNSAddPhysicalConstraint "PHYS_DEFAULT"
      '("width" "neck_width" "max_width")
      '(0.1 0.1 0.2)
    )
    (axlCNSSetPreferredWidth "PHYS_DEFAULT" 0.15)
    (axlCNSSetNetClassConstraint "PHYS_DEFAULT" "DEFAULT")

    ; ---- Physical Constraint: PHYS_CAN ----
    (printf "Setting Physical: PHYS_CAN\n")
    (axlCNSAddPhysicalConstraint "PHYS_CAN"
      '("width" "neck_width" "max_width")
      '(0.1 0.1 0.2)
    )
    (axlCNSSetPreferredWidth "PHYS_CAN" 0.15)
    (axlCNSSetNetClassConstraint "PHYS_CAN" "CAN")

    (printf "\nPhysical constraints set: 13\n\n")

    ; ---- Spacing Constraint: SPC_POWER ----
    (printf "Setting Spacing: SPC_POWER\n")
    (axlCNSAddSpacingConstraint "SPC_POWER"
      '("line_to_line" "line_to_pin" "line_to_via")
      '(0.3 0.3 0.25)
    )
    (axlCNSSetNetClassConstraint "SPC_POWER" "POWER")

    ; ---- Spacing Constraint: SPC_GND ----
    (printf "Setting Spacing: SPC_GND\n")
    (axlCNSAddSpacingConstraint "SPC_GND"
      '("line_to_line" "line_to_pin" "line_to_via")
      '(0.3 0.3 0.25)
    )
    (axlCNSSetNetClassConstraint "SPC_GND" "GND")

    ; ---- Spacing Constraint: SPC_GATE_DRIVE ----
    (printf "Setting Spacing: SPC_GATE_DRIVE\n")
    (axlCNSAddSpacingConstraint "SPC_GATE_DRIVE"
      '("line_to_line" "line_to_pin" "line_to_via")
      '(0.5 0.5 0.5)
    )
    (axlCNSSetNetClassConstraint "SPC_GATE_DRIVE" "GATE_DRIVE")

    ; ---- Spacing Constraint: SPC_SENSE ----
    (printf "Setting Spacing: SPC_SENSE\n")
    (axlCNSAddSpacingConstraint "SPC_SENSE"
      '("line_to_line" "line_to_pin" "line_to_via")
      '(0.2 0.15 0.15)
    )
    (axlCNSSetNetClassConstraint "SPC_SENSE" "SENSE")

    ; ---- Spacing Constraint: SPC_CLOCK ----
    (printf "Setting Spacing: SPC_CLOCK\n")
    (axlCNSAddSpacingConstraint "SPC_CLOCK"
      '("line_to_line" "line_to_pin" "line_to_via")
      '(3W 0.3 0.25)
    )
    (axlCNSSetNetClassConstraint "SPC_CLOCK" "CLOCK")

    ; ---- Spacing Constraint: SPC_RESET ----
    (printf "Setting Spacing: SPC_RESET\n")
    (axlCNSAddSpacingConstraint "SPC_RESET"
      '("line_to_line" "line_to_pin" "line_to_via")
      '(5W 0.3 0.25)
    )
    (axlCNSSetNetClassConstraint "SPC_RESET" "RESET")

    ; ---- Spacing Constraint: SPC_SPI ----
    (printf "Setting Spacing: SPC_SPI\n")
    (axlCNSAddSpacingConstraint "SPC_SPI"
      '("line_to_line" "line_to_pin" "line_to_via")
      '(3W 0.15 0.15)
    )
    (axlCNSSetNetClassConstraint "SPC_SPI" "SPI")

    ; ---- Spacing Constraint: SPC_I2C ----
    (printf "Setting Spacing: SPC_I2C\n")
    (axlCNSAddSpacingConstraint "SPC_I2C"
      '("line_to_line" "line_to_pin" "line_to_via")
      '(0.15 0.15 0.15)
    )
    (axlCNSSetNetClassConstraint "SPC_I2C" "I2C")

    ; ---- Spacing Constraint: SPC_ETHERNET ----
    (printf "Setting Spacing: SPC_ETHERNET\n")
    (axlCNSAddSpacingConstraint "SPC_ETHERNET"
      '("line_to_line" "line_to_pin" "line_to_via")
      '(0.2 0.2 0.2)
    )
    (axlCNSSetNetClassConstraint "SPC_ETHERNET" "ETHERNET")

    ; ---- Spacing Constraint: SPC_LED ----
    (printf "Setting Spacing: SPC_LED\n")
    (axlCNSAddSpacingConstraint "SPC_LED"
      '("line_to_line" "line_to_pin" "line_to_via")
      '(0.15 0.15 0.15)
    )
    (axlCNSSetNetClassConstraint "SPC_LED" "LED")

    ; ---- Spacing Constraint: SPC_JTAG ----
    (printf "Setting Spacing: SPC_JTAG\n")
    (axlCNSAddSpacingConstraint "SPC_JTAG"
      '("line_to_line" "line_to_pin" "line_to_via")
      '(0.15 0.15 0.15)
    )
    (axlCNSSetNetClassConstraint "SPC_JTAG" "JTAG")

    ; ---- Spacing Constraint: SPC_DEFAULT ----
    (printf "Setting Spacing: SPC_DEFAULT\n")
    (axlCNSAddSpacingConstraint "SPC_DEFAULT"
      '("line_to_line" "line_to_pin" "line_to_via")
      '(0.15 0.15 0.15)
    )
    (axlCNSSetNetClassConstraint "SPC_DEFAULT" "DEFAULT")

    ; ---- Spacing Constraint: SPC_CAN ----
    (printf "Setting Spacing: SPC_CAN\n")
    (axlCNSAddSpacingConstraint "SPC_CAN"
      '("line_to_line" "line_to_pin" "line_to_via")
      '(0.2 0.2 0.2)
    )
    (axlCNSSetNetClassConstraint "SPC_CAN" "CAN")

    (printf "\nSpacing constraints set: 13\n\n")

    ; ---- Via Constraint: VIA_POWER ----
    (printf "Setting Via: VIA_POWER\n")
    (axlCNSAddViaConstraint "VIA_POWER"
      '("drill" "pad")
      '(0.25 0.5)
    )
    (axlCNSSetNetClassConstraint "VIA_POWER" "POWER")

    ; ---- Via Constraint: VIA_GND ----
    (printf "Setting Via: VIA_GND\n")
    (axlCNSAddViaConstraint "VIA_GND"
      '("drill" "pad")
      '(0.25 0.5)
    )
    (axlCNSSetNetClassConstraint "VIA_GND" "GND")

    ; ---- Via Constraint: VIA_GATE_DRIVE ----
    (printf "Setting Via: VIA_GATE_DRIVE\n")
    (axlCNSAddViaConstraint "VIA_GATE_DRIVE"
      '("drill" "pad")
      '(0.3 0.6)
    )
    (axlCNSSetNetClassConstraint "VIA_GATE_DRIVE" "GATE_DRIVE")

    ; ---- Via Constraint: VIA_SENSE ----
    (printf "Setting Via: VIA_SENSE\n")
    (axlCNSAddViaConstraint "VIA_SENSE"
      '("drill" "pad")
      '(0.2 0.4)
    )
    (axlCNSSetNetClassConstraint "VIA_SENSE" "SENSE")

    ; ---- Via Constraint: VIA_CLOCK ----
    (printf "Setting Via: VIA_CLOCK\n")
    (axlCNSAddViaConstraint "VIA_CLOCK"
      '("drill" "pad")
      '(0.2 0.4)
    )
    (axlCNSSetNetClassConstraint "VIA_CLOCK" "CLOCK")

    ; ---- Via Constraint: VIA_RESET ----
    (printf "Setting Via: VIA_RESET\n")
    (axlCNSAddViaConstraint "VIA_RESET"
      '("drill" "pad")
      '(0.2 0.4)
    )
    (axlCNSSetNetClassConstraint "VIA_RESET" "RESET")

    ; ---- Via Constraint: VIA_SPI ----
    (printf "Setting Via: VIA_SPI\n")
    (axlCNSAddViaConstraint "VIA_SPI"
      '("drill" "pad")
      '(0.2 0.4)
    )
    (axlCNSSetNetClassConstraint "VIA_SPI" "SPI")

    ; ---- Via Constraint: VIA_I2C ----
    (printf "Setting Via: VIA_I2C\n")
    (axlCNSAddViaConstraint "VIA_I2C"
      '("drill" "pad")
      '(0.2 0.4)
    )
    (axlCNSSetNetClassConstraint "VIA_I2C" "I2C")

    ; ---- Via Constraint: VIA_ETHERNET ----
    (printf "Setting Via: VIA_ETHERNET\n")
    (axlCNSAddViaConstraint "VIA_ETHERNET"
      '("drill" "pad")
      '(0.2 0.4)
    )
    (axlCNSSetNetClassConstraint "VIA_ETHERNET" "ETHERNET")

    ; ---- Via Constraint: VIA_LED ----
    (printf "Setting Via: VIA_LED\n")
    (axlCNSAddViaConstraint "VIA_LED"
      '("drill" "pad")
      '(0.2 0.4)
    )
    (axlCNSSetNetClassConstraint "VIA_LED" "LED")

    ; ---- Via Constraint: VIA_JTAG ----
    (printf "Setting Via: VIA_JTAG\n")
    (axlCNSAddViaConstraint "VIA_JTAG"
      '("drill" "pad")
      '(0.2 0.4)
    )
    (axlCNSSetNetClassConstraint "VIA_JTAG" "JTAG")

    ; ---- Via Constraint: VIA_DEFAULT ----
    (printf "Setting Via: VIA_DEFAULT\n")
    (axlCNSAddViaConstraint "VIA_DEFAULT"
      '("drill" "pad")
      '(0.2 0.4)
    )
    (axlCNSSetNetClassConstraint "VIA_DEFAULT" "DEFAULT")

    ; ---- Via Constraint: VIA_CAN ----
    (printf "Setting Via: VIA_CAN\n")
    (axlCNSAddViaConstraint "VIA_CAN"
      '("drill" "pad")
      '(0.2 0.4)
    )
    (axlCNSSetNetClassConstraint "VIA_CAN" "CAN")

    (printf "\nVia constraints set: 13\n\n")

    ; ---- Diff Pair: DP_1 ----
    (printf "Creating Diff Pair: DP_1\n")
    (axlCNSAddDiffPair "DP_1"
      "ETH_MDI0_P" "ETH_MDI0_N"
    )

    ; ---- Diff Pair: DP_2 ----
    (printf "Creating Diff Pair: DP_2\n")
    (axlCNSAddDiffPair "DP_2"
      "ETH_MDI1_P" "ETH_MDI1_N"
    )

    ; ---- Diff Pair: DP_3 ----
    (printf "Creating Diff Pair: DP_3\n")
    (axlCNSAddDiffPair "DP_3"
      "ETH_MDI2_P" "ETH_MDI2_N"
    )

    ; ---- Diff Pair: DP_4 ----
    (printf "Creating Diff Pair: DP_4\n")
    (axlCNSAddDiffPair "DP_4"
      "ETH_MDI3_P" "ETH_MDI3_N"
    )

    (printf "\nDiff Pairs created: 4\n\n")

    ; ---- Electrical Constraint: ELEC_ETHERNET ----
    (printf "Setting Electrical: ELEC_ETHERNET\n")
    (axlCNSAddElectricalConstraint "ELEC_ETHERNET"
      '("diff_pair_impedance" "diff_pair_line_width" "diff_pair_gap")
      '(100 0.09 0.09)
    )
    (axlCNSSetDiffPairImpedanceTolerance "ELEC_ETHERNET" 10)
    (axlCNSSetNetClassConstraint "ELEC_ETHERNET" "ETHERNET")

    ; ---- Electrical Constraint: ELEC_CAN ----
    (printf "Setting Electrical: ELEC_CAN\n")
    (axlCNSAddElectricalConstraint "ELEC_CAN"
      '("diff_pair_impedance" "diff_pair_line_width" "diff_pair_gap")
      '(100 0.1 0.1)
    )
    (axlCNSSetDiffPairImpedanceTolerance "ELEC_CAN" 10)
    (axlCNSSetNetClassConstraint "ELEC_CAN" "CAN")

    (printf "\nElectrical constraints set: 2\n\n")

    ; ---- 退出 Constraint Manager ----
    (axlCNSExit)

    (printf "\n========================================\n")
    (printf "BRD-AI: Constraint 创建完成!\n")
    (printf "========================================\n\n")
    t
  )
)

; ---- 执行 ----
(BRD_AI_CreateAllConstraints)
